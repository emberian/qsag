* NGSPICE file created from envD.ext - technology: gf180mcuD

.option scale=5n

X0 u0/ZN u0/A2 u5/VDD u5/VNW pfet_05v0 ad=11.752n pd=0.33m as=19.888n ps=0.628m w=226 l=100
X1 u0/ZN u0/A1 u0/a_245_68# VSUBS nfet_05v0 ad=14.432n pd=0.504m as=5.248n ps=0.228m w=164 l=120
X2 u5/VDD u0/A1 u0/ZN u5/VNW pfet_05v0 ad=19.888n pd=0.628m as=11.752n ps=0.33m w=226 l=100
X3 u0/a_245_68# u0/A2 u5/VSS VSUBS nfet_05v0 ad=5.248n pd=0.228m as=14.432n ps=0.504m w=164 l=120
X4 u1/ZN u1/A2 u5/VDD u5/VNW pfet_05v0 ad=23.504n pd=0.66m as=0.1591u ps=5.024m w=226 l=100
X5 u1/ZN u1/A1 u1/a_245_68# VSUBS nfet_05v0 ad=14.432n pd=0.504m as=10.496n ps=0.456m w=164 l=120
X6 u5/VDD u1/A1 u1/ZN u5/VNW pfet_05v0 ad=0 pd=0 as=0 ps=0 w=226 l=100
X7 u1/a_245_68# u1/A2 u5/VSS VSUBS nfet_05v0 ad=0 pd=0 as=57.728n ps=2.016m w=164 l=120
X8 u2/ZN u2/A2 u5/VDD u5/VNW pfet_05v0 ad=23.504n pd=0.66m as=0 ps=0 w=226 l=100
X9 u2/ZN u2/A1 u2/a_245_68# VSUBS nfet_05v0 ad=14.432n pd=0.504m as=10.496n ps=0.456m w=164 l=120
X10 u5/VDD u2/A1 u2/ZN u5/VNW pfet_05v0 ad=0 pd=0 as=0 ps=0 w=226 l=100
X11 u2/a_245_68# u2/A2 u5/VSS VSUBS nfet_05v0 ad=0 pd=0 as=0 ps=0 w=164 l=120
X12 u5/ZN u5/A2 u5/VDD u5/VNW pfet_05v0 ad=23.504n pd=0.66m as=0 ps=0 w=226 l=100
X13 u5/ZN u5/A1 u5/a_245_68# VSUBS nfet_05v0 ad=14.432n pd=0.504m as=10.496n ps=0.456m w=164 l=120
X14 u5/VDD u5/A1 u5/ZN u5/VNW pfet_05v0 ad=0 pd=0 as=0 ps=0 w=226 l=100
X15 u5/a_245_68# u5/A2 u5/VSS VSUBS nfet_05v0 ad=0 pd=0 as=0 ps=0 w=164 l=120
C0 u5/VNW u2/A2 0.1256f
C1 u5/ZN u5/VDD 0.24727f
C2 u1/A2 u5/VNW 0.1256f
C3 u5/A2 u2/A1 0.00774f
C4 u1/ZN u5/VDD 0.24816f
C5 u5/VNW u1/A1 0.12122f
C6 u1/ZN u2/A2 0.07165f
C7 u1/ZN u1/A2 0.04777f
C8 u2/ZN u5/VSS 0.10829f
C9 u5/VNW u2/A1 0.12528f
C10 u5/ZN u2/A1 0
C11 u1/ZN u1/a_245_68# 0
C12 u0/ZN u0/a_245_68# 0
C13 u2/A2 u5/VDD 0.04933f
C14 u0/A2 u0/ZN 0.04777f
C15 u1/A2 u5/VDD 0.04933f
C16 u2/ZN u5/A2 0.02755f
C17 u5/VDD u1/a_245_68# 0
C18 u1/ZN u1/A1 0.36366f
C19 u1/ZN u2/A1 0.00789f
C20 u1/A2 u1/a_245_68# 0
C21 u1/A1 u5/VDD 0.0371f
C22 u2/ZN u5/VNW 0.04971f
C23 u1/A1 u2/A2 0.0148f
C24 u5/VDD u2/A1 0.03726f
C25 u1/A2 u1/A1 0.2264f
C26 u5/VSS u0/ZN 0.13796f
C27 u2/A2 u2/A1 0.2264f
C28 u2/ZN u5/ZN 0.00449f
C29 u1/A1 u1/a_245_68# 0.00883f
C30 u2/ZN u1/ZN 0.00724f
C31 u5/A1 u5/a_245_68# 0.00883f
C32 u0/A1 u0/ZN 0.36366f
C33 u2/ZN u5/VDD 0.24786f
C34 u2/ZN u2/A2 0.04777f
C35 u5/VNW u0/ZN 0.04307f
C36 u0/A2 u0/a_245_68# 0
C37 u5/VSS u2/a_245_68# 0.00291f
C38 u2/ZN u1/A1 0
C39 u1/ZN u0/ZN 0.00724f
C40 u5/A1 u5/VSS 0.13214f
C41 u2/ZN u2/A1 0.36366f
C42 u5/a_245_68# u5/VSS 0.00268f
C43 u5/VSS u0/a_245_68# 0.00317f
C44 u5/VSS u0/A2 0.05529f
C45 u5/VDD u0/ZN 0.24758f
C46 u5/A1 u5/A2 0.2264f
C47 u5/a_245_68# u5/A2 0
C48 u1/A2 u0/ZN 0.07165f
C49 u0/ZN u1/a_245_68# 0
C50 u0/A1 u0/a_245_68# 0.00883f
C51 u5/A1 u5/VNW 0.11976f
C52 u0/A2 u0/A1 0.2264f
C53 u1/A1 u0/ZN 0.00789f
C54 u5/A1 u5/ZN 0.36366f
C55 u5/VNW u0/A2 0.1254f
C56 u5/a_245_68# u5/ZN 0
C57 u1/ZN u2/a_245_68# 0
C58 u5/A2 u5/VSS 0.05581f
C59 u2/a_245_68# u5/VDD 0
C60 u2/A2 u2/a_245_68# 0
C61 u5/VSS u0/A1 0.13456f
C62 u5/A1 u5/VDD 0.03659f
C63 u5/VNW u5/VSS 0.03561f
C64 u5/a_245_68# u5/VDD 0
C65 u5/VDD u0/a_245_68# 0
C66 u5/VSS u5/ZN 0.09851f
C67 u5/VDD u0/A2 0.04881f
C68 u5/VNW u5/A2 0.13414f
C69 u2/a_245_68# u2/A1 0.00883f
C70 u5/A2 u5/ZN 0.04777f
C71 u1/ZN u5/VSS 0.13796f
C72 u5/VNW u0/A1 0.12122f
C73 u5/VSS u5/VDD 0.0847f
C74 u5/VSS u2/A2 0.05562f
C75 u5/VNW u5/ZN 0.04362f
C76 u1/A2 u5/VSS 0.056f
C77 u5/A2 u5/VDD 0.0495f
C78 u5/VSS u1/a_245_68# 0.00317f
C79 u2/ZN u2/a_245_68# 0
C80 u1/ZN u0/A1 0
C81 u1/ZN u5/VNW 0.04264f
C82 u1/A1 u5/VSS 0.13456f
C83 u5/A1 u2/ZN 0.00425f
C84 u5/VDD u0/A1 0.0371f
C85 u5/VSS u2/A1 0.13401f
C86 u5/a_245_68# u2/ZN 0
C87 u5/VNW u5/VDD 0.48554f
C88 u1/A2 u0/A1 0.0148f
C89 u5/ZN VSUBS 0.08833f
C90 u5/A1 VSUBS 0.17937f
C91 u5/A2 VSUBS 0.20324f
C92 u5/VSS VSUBS 0.82983f
C93 u5/VDD VSUBS 0.59247f
C94 u5/VNW VSUBS 4.09635f
C95 u2/ZN VSUBS 0.08833f
C96 u2/A1 VSUBS 0.17937f
C97 u2/A2 VSUBS 0.20324f
C98 u1/ZN VSUBS 0.08833f
C99 u1/A1 VSUBS 0.17937f
C100 u1/A2 VSUBS 0.20324f
C101 u0/ZN VSUBS 0.08833f
C102 u0/A1 VSUBS 0.17937f
C103 u0/A2 VSUBS 0.20324f
