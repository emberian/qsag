* NGSPICE file created from envC.ext - technology: gf180mcuD

.option scale=5n

X0 u0/Z u0/a_36_68# u2/VDD u2/VNW pfet_05v0 ad=15.128n pd=0.368m as=19.764n ps=0.406m w=244 l=100
X1 u2/VSS u0/I u0/a_36_68# VSUBS nfet_05v0 ad=11.644n pd=0.306m as=14.432n ps=0.504m w=164 l=120
X2 u0/Z u0/a_36_68# u2/VSS VSUBS nfet_05v0 ad=8.528n pd=0.268m as=11.644n ps=0.306m w=164 l=120
X3 u2/VDD u0/I u0/a_36_68# u2/VNW pfet_05v0 ad=19.764n pd=0.406m as=21.472n ps=0.664m w=244 l=100
X4 u2/VSS u0/a_36_68# u0/Z VSUBS nfet_05v0 ad=14.432n pd=0.504m as=8.528n ps=0.268m w=164 l=120
X5 u2/VDD u0/a_36_68# u0/Z u2/VNW pfet_05v0 ad=21.472n pd=0.664m as=15.128n ps=0.368m w=244 l=100
X6 u1/ZN u1/A2 u2/VDD u2/VNW pfet_05v0 ad=11.752n pd=0.33m as=19.888n ps=0.628m w=226 l=100
X7 u1/ZN u1/A1 u1/a_245_68# VSUBS nfet_05v0 ad=14.432n pd=0.504m as=5.248n ps=0.228m w=164 l=120
X8 u2/VDD u1/A1 u1/ZN u2/VNW pfet_05v0 ad=19.888n pd=0.628m as=11.752n ps=0.33m w=226 l=100
X9 u1/a_245_68# u1/A2 u2/VSS VSUBS nfet_05v0 ad=5.248n pd=0.228m as=14.432n ps=0.504m w=164 l=120
X10 u2/VSS u2/CLK u2/a_36_151# VSUBS nfet_05v0 ad=4.212n pd=0.185m as=7.128n ps=0.338m w=81 l=120
X11 u2/Q u2/a_2304_115# u2/VSS VSUBS nfet_05v0 ad=14.432n pd=0.504m as=14.432n ps=0.504m w=164 l=120
X12 u2/a_2304_115# u2/a_2011_527# u2/VSS VSUBS nfet_05v0 ad=7.04n pd=0.336m as=5.68n ps=0.228m w=80 l=120
X13 u2/a_1004_159# u2/D u2/a_836_159# VSUBS nfet_05v0 ad=8.28n pd=0.302m as=1.728n ps=0.12m w=72 l=120
X14 u2/a_1004_159# u2/D u2/a_880_527# u2/VNW pfet_05v0 ad=7.488n pd=0.28m as=2.16n ps=0.132m w=72 l=100
X15 u2/a_2011_527# u2/a_36_151# u2/a_1376_115# u2/VNW pfet_05v0 ad=6.66n pd=0.257m as=7.164n ps=0.271m w=72 l=100
X16 u2/a_2296_527# u2/a_448_472# u2/a_2011_527# u2/VNW pfet_05v0 ad=2.016n pd=0.128m as=6.66n ps=0.257m w=72 l=100
X17 u2/a_1376_115# u2/a_1004_159# u2/VDD u2/VNW pfet_05v0 ad=7.164n pd=0.271m as=4.176n ps=0.188m w=72 l=100
X18 u2/VDD u2/CLK u2/a_36_151# u2/VNW pfet_05v0 ad=8.996n pd=0.277m as=15.224n ps=0.522m w=173 l=100
X19 u2/VSS u2/a_1376_115# u2/a_1328_159# VSUBS nfet_05v0 ad=10.548n pd=0.365m as=1.728n ps=0.12m w=72 l=120
X20 u2/a_2011_527# u2/a_448_472# u2/a_1376_115# VSUBS nfet_05v0 ad=3.744n pd=0.176m as=3.744n ps=0.176m w=72 l=120
X21 u2/a_448_472# u2/a_36_151# u2/VDD u2/VNW pfet_05v0 ad=15.224n pd=0.522m as=8.996n ps=0.277m w=173 l=100
X22 u2/Q u2/a_2304_115# u2/VDD u2/VNW pfet_05v0 ad=21.472n pd=0.664m as=21.472n ps=0.664m w=244 l=100
X23 u2/a_1376_115# u2/a_1004_159# u2/VSS VSUBS nfet_05v0 ad=3.744n pd=0.176m as=10.548n ps=0.365m w=72 l=120
X24 u2/VSS u2/a_2304_115# u2/a_2256_159# VSUBS nfet_05v0 ad=5.68n pd=0.228m as=1.728n ps=0.12m w=72 l=120
X25 u2/a_836_159# u2/a_36_151# u2/VSS VSUBS nfet_05v0 ad=1.728n pd=0.12m as=6.336n ps=0.32m w=72 l=120
X26 u2/a_448_472# u2/a_36_151# u2/VSS VSUBS nfet_05v0 ad=7.128n pd=0.338m as=4.212n ps=0.185m w=81 l=120
X27 u2/a_2256_159# u2/a_36_151# u2/a_2011_527# VSUBS nfet_05v0 ad=1.728n pd=0.12m as=3.744n ps=0.176m w=72 l=120
X28 u2/a_880_527# u2/a_448_472# u2/VDD u2/VNW pfet_05v0 ad=2.16n pd=0.132m as=18.216n ps=0.65m w=72 l=100
X29 u2/a_1348_527# u2/a_36_151# u2/a_1004_159# u2/VNW pfet_05v0 ad=1.728n pd=0.12m as=7.488n ps=0.28m w=72 l=100
X30 u2/a_1328_159# u2/a_448_472# u2/a_1004_159# VSUBS nfet_05v0 ad=1.728n pd=0.12m as=8.28n ps=0.302m w=72 l=120
X31 u2/VDD u2/a_1376_115# u2/a_1348_527# u2/VNW pfet_05v0 ad=4.176n pd=0.188m as=1.728n ps=0.12m w=72 l=100
X32 u2/VDD u2/a_2304_115# u2/a_2296_527# u2/VNW pfet_05v0 ad=9.2n pd=0.308m as=2.016n ps=0.128m w=72 l=100
X33 u2/a_2304_115# u2/a_2011_527# u2/VDD u2/VNW pfet_05v0 ad=14.08n pd=0.496m as=9.2n ps=0.308m w=160 l=100
C0 u2/a_36_151# u1/A2 0
C1 u1/A1 u2/VDD 0.03756f
C2 u2/VDD u1/a_245_68# 0
C3 u1/A1 u1/ZN 0.36366f
C4 u1/ZN u1/a_245_68# 0
C5 u2/CLK u0/a_36_68# 0
C6 u2/a_36_151# u2/VNW 0.96787f
C7 u2/a_2011_527# u2/a_1376_115# 0.02112f
C8 u2/VSS u2/a_36_151# 0.24119f
C9 u2/CLK u2/a_448_472# 0.00119f
C10 u2/a_2011_527# u2/a_1004_159# 0
C11 u2/a_2011_527# u2/a_2256_159# 0.00232f
C12 u2/a_1004_159# u2/a_836_159# 0
C13 u2/D u2/VDD 0.00349f
C14 u2/CLK u0/Z 0
C15 u2/VSS u2/a_1328_159# 0.00147f
C16 u2/a_2304_115# u2/a_448_472# 0.02307f
C17 u2/VNW u0/I 0.13333f
C18 u2/Q u2/a_2304_115# 0.17225f
C19 u2/VDD u1/ZN 0.24744f
C20 u2/VSS u0/I 0.12874f
C21 u1/A1 u0/a_36_68# 0
C22 u2/a_2011_527# u2/a_36_151# 0.04722f
C23 u2/a_36_151# u2/a_836_159# 0
C24 u1/A1 u0/Z 0.00388f
C25 u0/Z u1/a_245_68# 0
C26 u2/VDD u0/a_36_68# 0.27896f
C27 u2/VDD u2/a_2296_527# 0.0029f
C28 u2/a_2304_115# u2/a_2256_159# 0
C29 u2/D u2/a_448_472# 0.24298f
C30 u2/VDD u2/a_448_472# 0.68377f
C31 u2/Q u2/VDD 0.15434f
C32 u1/ZN u2/a_448_472# 0
C33 u0/Z u2/VDD 0.1961f
C34 u2/VNW u1/A2 0.13019f
C35 u0/Z u1/ZN 0.00742f
C36 u2/VSS u1/A2 0.05616f
C37 u2/CLK u2/a_36_151# 0.48569f
C38 u2/VSS u2/VNW 0.02693f
C39 u2/D u2/a_880_527# 0.00144f
C40 u2/a_2304_115# u2/a_36_151# 0.03873f
C41 u2/VDD u2/a_880_527# 0
C42 u2/CLK u0/I 0
C43 u2/D u2/a_1376_115# 0.00472f
C44 u2/a_1376_115# u2/VDD 0.01976f
C45 u2/D u2/a_1004_159# 0.20652f
C46 u2/a_2296_527# u2/a_448_472# 0
C47 u2/VDD u2/a_1004_159# 0.16054f
C48 u0/Z u0/a_36_68# 0.4568f
C49 u1/A1 u2/a_36_151# 0.00163f
C50 u0/Z u2/a_448_472# 0
C51 u2/a_2011_527# u2/VNW 0.24182f
C52 u2/VSS u2/a_2011_527# 0.1119f
C53 u2/D u2/a_36_151# 0.1215f
C54 u2/VDD u2/a_36_151# 1.25472f
C55 u2/a_880_527# u2/a_448_472# 0
C56 u1/ZN u2/a_36_151# 0.10404f
C57 u2/a_1348_527# u2/VDD 0.00246f
C58 u2/a_1376_115# u2/a_448_472# 1.16478f
C59 u2/VDD u0/I 0.02914f
C60 u2/a_1004_159# u2/a_448_472# 0.83991f
C61 u2/a_448_472# u2/a_2256_159# 0
C62 u2/CLK u2/VNW 0.13535f
C63 u2/CLK u2/VSS 0.02207f
C64 u2/a_2304_115# u2/VNW 0.33869f
C65 u2/VSS u2/a_2304_115# 0.27806f
C66 u2/a_1004_159# u2/a_880_527# 0
C67 u1/A1 u1/A2 0.2264f
C68 u2/a_36_151# u2/a_448_472# 0.72261f
C69 u1/a_245_68# u1/A2 0
C70 u0/Z u2/a_36_151# 0
C71 u0/I u0/a_36_68# 0.74097f
C72 u2/a_1328_159# u2/a_448_472# 0.00306f
C73 u2/a_1376_115# u2/a_1004_159# 0.10745f
C74 u1/A1 u2/VNW 0.12359f
C75 u2/a_1348_527# u2/a_448_472# 0
C76 u2/VSS u1/A1 0.13539f
C77 u2/VSS u1/a_245_68# 0.00291f
C78 u2/VDD u1/A2 0.04947f
C79 u0/Z u0/I 0.02065f
C80 u2/a_2011_527# u2/a_2304_115# 0.49964f
C81 u1/ZN u1/A2 0.04777f
C82 u2/a_880_527# u2/a_36_151# 0.00384f
C83 u2/D u2/VNW 0.179f
C84 u2/VDD u2/VNW 0.70361f
C85 u1/ZN u2/VNW 0.04449f
C86 u2/D u2/VSS 0.00349f
C87 u2/VSS u2/VDD 0.03986f
C88 u2/a_1376_115# u2/a_36_151# 0.08109f
C89 u2/VSS u1/ZN 0.10741f
C90 u2/a_1004_159# u2/a_36_151# 0.22071f
C91 u2/a_1376_115# u2/a_1328_159# 0
C92 u2/a_1348_527# u2/a_1004_159# 0.00275f
C93 u0/a_36_68# u1/A2 0.01196f
C94 u2/a_2011_527# u2/VDD 0.12733f
C95 u2/VNW u0/a_36_68# 0.31751f
C96 u0/Z u1/A2 0.03921f
C97 u2/VSS u0/a_36_68# 0.15722f
C98 u2/VNW u2/a_448_472# 0.42607f
C99 u2/Q u2/VNW 0.03696f
C100 u2/a_1348_527# u2/a_36_151# 0
C101 u0/Z u2/VNW 0.04542f
C102 u2/VSS u2/a_448_472# 0.8973f
C103 u2/Q u2/VSS 0.10956f
C104 u2/CLK u1/A1 0.01052f
C105 u2/VSS u0/Z 0.13911f
C106 u2/a_2011_527# u2/a_2296_527# 0.00277f
C107 u2/CLK u2/VDD 0.02241f
C108 u2/CLK u1/ZN 0.03026f
C109 u2/a_2011_527# u2/a_448_472# 0.41635f
C110 u2/a_1376_115# u2/VNW 0.167f
C111 u2/Q u2/a_2011_527# 0
C112 u2/a_2304_115# u2/VDD 0.17917f
C113 u2/a_836_159# u2/a_448_472# 0.00393f
C114 u2/a_1004_159# u2/VNW 0.24039f
C115 u1/A1 u1/a_245_68# 0.00883f
C116 u2/VSS u2/a_1376_115# 0.14376f
C117 u2/VSS u2/a_1004_159# 0.01386f
C118 u2/VSS u2/a_2256_159# 0.00239f
C119 u2/Q VSUBS 0.09456f
C120 u2/D VSUBS 0.1666f
C121 u2/CLK VSUBS 0.17676f
C122 u2/a_2304_115# VSUBS 0.37835f ; **FLOATING
C123 u2/a_2011_527# VSUBS 0.26006f ; **FLOATING
C124 u2/a_1004_159# VSUBS 0.17588f ; **FLOATING
C125 u2/a_1376_115# VSUBS 0.16786f ; **FLOATING
C126 u2/a_448_472# VSUBS 0.3638f ; **FLOATING
C127 u2/a_36_151# VSUBS 0.70439f ; **FLOATING
C128 u2/VSS VSUBS 1.59832f
C129 u1/ZN VSUBS 0.08833f
C130 u2/VDD VSUBS 0.95211f
C131 u1/A1 VSUBS 0.17937f
C132 u1/A2 VSUBS 0.20324f
C133 u2/VNW VSUBS 7.55848f
C134 u0/Z VSUBS 0.07302f
C135 u0/I VSUBS 0.18726f
C136 u0/a_36_68# VSUBS 0.45233f ; **FLOATING
