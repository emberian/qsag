* NGSPICE file created from envA.ext - technology: gf180mcuD

.option scale=5n

X0 u0/ZN u0/A2 u4/VDD u4/VNW pfet_05v0 ad=11.752n pd=0.33m as=19.888n ps=0.628m w=226 l=100
X1 u0/ZN u0/A1 u0/a_245_68# VSUBS nfet_05v0 ad=14.432n pd=0.504m as=5.248n ps=0.228m w=164 l=120
X2 u4/VDD u0/A1 u0/ZN u4/VNW pfet_05v0 ad=19.888n pd=0.628m as=11.752n ps=0.33m w=226 l=100
X3 u0/a_245_68# u0/A2 u4/VSS VSUBS nfet_05v0 ad=5.248n pd=0.228m as=14.432n ps=0.504m w=164 l=120
X4 u1/ZN u1/A2 u4/VDD u4/VNW pfet_05v0 ad=23.504n pd=0.66m as=0.19888u ps=6.28m w=226 l=100
X5 u1/ZN u1/A1 u1/a_245_68# VSUBS nfet_05v0 ad=14.432n pd=0.504m as=10.496n ps=0.456m w=164 l=120
X6 u4/VDD u1/A1 u1/ZN u4/VNW pfet_05v0 ad=0 pd=0 as=0 ps=0 w=226 l=100
X7 u1/a_245_68# u1/A2 u4/VSS VSUBS nfet_05v0 ad=0 pd=0 as=72.16n ps=2.52m w=164 l=120
X8 u2/ZN u2/A2 u4/VDD u4/VNW pfet_05v0 ad=23.504n pd=0.66m as=0 ps=0 w=226 l=100
X9 u2/ZN u2/A1 u2/a_245_68# VSUBS nfet_05v0 ad=14.432n pd=0.504m as=10.496n ps=0.456m w=164 l=120
X10 u4/VDD u2/A1 u2/ZN u4/VNW pfet_05v0 ad=0 pd=0 as=0 ps=0 w=226 l=100
X11 u2/a_245_68# u2/A2 u4/VSS VSUBS nfet_05v0 ad=0 pd=0 as=0 ps=0 w=164 l=120
X12 u3/ZN u3/A2 u4/VDD u4/VNW pfet_05v0 ad=23.504n pd=0.66m as=0 ps=0 w=226 l=100
X13 u3/ZN u3/A1 u3/a_245_68# VSUBS nfet_05v0 ad=14.432n pd=0.504m as=10.496n ps=0.456m w=164 l=120
X14 u4/VDD u3/A1 u3/ZN u4/VNW pfet_05v0 ad=0 pd=0 as=0 ps=0 w=226 l=100
X15 u3/a_245_68# u3/A2 u4/VSS VSUBS nfet_05v0 ad=0 pd=0 as=0 ps=0 w=164 l=120
X16 u4/ZN u4/A2 u4/VDD u4/VNW pfet_05v0 ad=23.504n pd=0.66m as=0 ps=0 w=226 l=100
X17 u4/ZN u4/A1 u4/a_245_68# VSUBS nfet_05v0 ad=14.432n pd=0.504m as=10.496n ps=0.456m w=164 l=120
X18 u4/VDD u4/A1 u4/ZN u4/VNW pfet_05v0 ad=0 pd=0 as=0 ps=0 w=226 l=100
X19 u4/a_245_68# u4/A2 u4/VSS VSUBS nfet_05v0 ad=0 pd=0 as=0 ps=0 w=164 l=120
C0 u3/A2 u3/a_245_68# 0
C1 u1/a_245_68# u1/A2 0
C2 u4/VSS u1/A2 0.056f
C3 u4/VNW u1/A1 0.12122f
C4 u1/a_245_68# u4/VDD 0
C5 u4/VSS u4/VDD 0.08853f
C6 u4/ZN u4/a_245_68# 0
C7 u4/ZN u4/A2 0.04777f
C8 u3/A2 u4/VDD 0.04933f
C9 u2/A2 u4/VDD 0.04933f
C10 u4/A2 u3/A1 0.0148f
C11 u0/A1 u1/ZN 0
C12 u0/a_245_68# u0/A1 0.00883f
C13 u4/VNW u1/A2 0.1256f
C14 u0/A1 u0/ZN 0.36366f
C15 u4/a_245_68# u3/ZN 0
C16 u4/A2 u3/ZN 0.07165f
C17 u4/VNW u4/VDD 0.51515f
C18 u1/A2 u1/A1 0.2264f
C19 u4/a_245_68# u4/A1 0.00883f
C20 u4/A2 u4/A1 0.2264f
C21 u4/VDD u1/A1 0.0371f
C22 u4/VSS u0/A1 0.13456f
C23 u3/a_245_68# u4/VDD 0
C24 u4/VSS u4/a_245_68# 0.00268f
C25 u4/VSS u4/A2 0.05527f
C26 u4/ZN u3/A1 0
C27 u0/A2 u0/a_245_68# 0
C28 u2/a_245_68# u2/A1 0.00883f
C29 u2/ZN u2/A1 0.36366f
C30 u0/A2 u0/ZN 0.04777f
C31 u2/A1 u3/ZN 0
C32 u1/A2 u4/VDD 0.04933f
C33 u4/ZN u3/ZN 0.00724f
C34 u2/A1 u1/ZN 0.00789f
C35 u4/VNW u0/A1 0.12122f
C36 u2/ZN u3/A1 0.00789f
C37 u4/ZN u4/A1 0.36366f
C38 u3/A1 u3/ZN 0.36366f
C39 u2/a_245_68# u2/ZN 0
C40 u0/A2 u4/VSS 0.05529f
C41 u4/VNW u4/A2 0.1256f
C42 u2/ZN u3/ZN 0.00724f
C43 u2/a_245_68# u1/ZN 0
C44 u2/ZN u1/ZN 0.00724f
C45 u4/VSS u2/A1 0.13456f
C46 u4/ZN u4/VSS 0.09851f
C47 u4/A1 u3/ZN 0.00789f
C48 u3/A2 u2/A1 0.0148f
C49 u1/ZN u0/ZN 0.00724f
C50 u0/a_245_68# u0/ZN 0
C51 u2/A2 u2/A1 0.2264f
C52 u4/VSS u3/A1 0.13456f
C53 u1/A2 u0/A1 0.0148f
C54 u0/A2 u4/VNW 0.1254f
C55 u4/VSS u2/a_245_68# 0.00317f
C56 u4/VSS u2/ZN 0.13796f
C57 u3/A2 u3/A1 0.2264f
C58 u0/A1 u4/VDD 0.0371f
C59 u4/VSS u3/ZN 0.13796f
C60 u1/a_245_68# u1/ZN 0
C61 u3/A2 u2/ZN 0.07165f
C62 u4/VNW u2/A1 0.12122f
C63 u4/VSS u1/ZN 0.13796f
C64 u4/VSS u0/a_245_68# 0.00317f
C65 u1/a_245_68# u0/ZN 0
C66 u2/a_245_68# u2/A2 0
C67 u4/VSS u0/ZN 0.13796f
C68 u3/A2 u3/ZN 0.04777f
C69 u4/a_245_68# u4/VDD 0
C70 u4/VSS u4/A1 0.13214f
C71 u4/ZN u4/VNW 0.04134f
C72 u2/ZN u2/A2 0.04777f
C73 u4/A2 u4/VDD 0.04933f
C74 u2/A2 u1/ZN 0.07165f
C75 u4/VNW u3/A1 0.12122f
C76 u4/VSS u1/a_245_68# 0.00317f
C77 u2/ZN u4/VNW 0.04264f
C78 u4/VNW u3/ZN 0.04264f
C79 u4/VNW u1/ZN 0.04264f
C80 u2/ZN u1/A1 0
C81 u3/A2 u4/VSS 0.056f
C82 u3/a_245_68# u3/A1 0.00883f
C83 u4/VNW u0/ZN 0.04307f
C84 u0/A2 u4/VDD 0.04881f
C85 u4/VNW u4/A1 0.11976f
C86 u4/VSS u2/A2 0.056f
C87 u1/A1 u1/ZN 0.36366f
C88 u3/a_245_68# u2/ZN 0
C89 u1/A1 u0/ZN 0.00789f
C90 u3/a_245_68# u3/ZN 0
C91 u4/VDD u2/A1 0.0371f
C92 u4/ZN u4/VDD 0.24758f
C93 u4/VSS u4/VNW 0.03087f
C94 u3/A1 u4/VDD 0.0371f
C95 u4/a_245_68# u4/A2 0
C96 u1/a_245_68# u1/A1 0.00883f
C97 u3/A2 u4/VNW 0.1256f
C98 u4/VSS u1/A1 0.13456f
C99 u2/a_245_68# u4/VDD 0
C100 u1/A2 u1/ZN 0.04777f
C101 u2/ZN u4/VDD 0.24816f
C102 u4/VNW u2/A2 0.1256f
C103 u1/A2 u0/ZN 0.07165f
C104 u4/VDD u3/ZN 0.24816f
C105 u4/VSS u3/a_245_68# 0.00317f
C106 u4/VDD u1/ZN 0.24816f
C107 u0/a_245_68# u4/VDD 0
C108 u2/A2 u1/A1 0.0148f
C109 u0/A2 u0/A1 0.2264f
C110 u4/VDD u0/ZN 0.24758f
C111 u4/A1 u4/VDD 0.03659f
C112 u4/ZN VSUBS 0.08833f
C113 u4/A1 VSUBS 0.17937f
C114 u4/A2 VSUBS 0.20324f
C115 u4/VSS VSUBS 0.907f
C116 u3/ZN VSUBS 0.08833f
C117 u4/VDD VSUBS 0.65248f
C118 u3/A1 VSUBS 0.17937f
C119 u3/A2 VSUBS 0.20324f
C120 u4/VNW VSUBS 4.6185f
C121 u2/ZN VSUBS 0.08833f
C122 u2/A1 VSUBS 0.17937f
C123 u2/A2 VSUBS 0.20324f
C124 u1/ZN VSUBS 0.08833f
C125 u1/A1 VSUBS 0.17937f
C126 u1/A2 VSUBS 0.20324f
C127 u0/ZN VSUBS 0.08833f
C128 u0/A1 VSUBS 0.17937f
C129 u0/A2 VSUBS 0.20324f
