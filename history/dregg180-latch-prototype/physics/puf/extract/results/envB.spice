* NGSPICE file created from envB.ext - technology: gf180mcuD

.option scale=5n

X0 u0/ZN u0/A2 u2/VDD u2/VNW pfet_05v0 ad=11.752n pd=0.33m as=19.888n ps=0.628m w=226 l=100
X1 u0/ZN u0/A1 u0/a_245_68# VSUBS nfet_05v0 ad=14.432n pd=0.504m as=5.248n ps=0.228m w=164 l=120
X2 u2/VDD u0/A1 u0/ZN u2/VNW pfet_05v0 ad=19.888n pd=0.628m as=11.752n ps=0.33m w=226 l=100
X3 u0/a_245_68# u0/A2 u2/VSS VSUBS nfet_05v0 ad=5.248n pd=0.228m as=14.432n ps=0.504m w=164 l=120
X4 u1/ZN u1/A2 u2/VDD u2/VNW pfet_05v0 ad=23.504n pd=0.66m as=0.11933u ps=3.768m w=226 l=100
X5 u1/ZN u1/A1 u1/a_245_68# VSUBS nfet_05v0 ad=14.432n pd=0.504m as=10.496n ps=0.456m w=164 l=120
X6 u2/VDD u1/A1 u1/ZN u2/VNW pfet_05v0 ad=0 pd=0 as=0 ps=0 w=226 l=100
X7 u1/a_245_68# u1/A2 u2/VSS VSUBS nfet_05v0 ad=0 pd=0 as=43.296n ps=1.512m w=164 l=120
X8 u2/ZN u2/A2 u2/VDD u2/VNW pfet_05v0 ad=23.504n pd=0.66m as=0 ps=0 w=226 l=100
X9 u2/ZN u2/A1 u2/a_245_68# VSUBS nfet_05v0 ad=14.432n pd=0.504m as=10.496n ps=0.456m w=164 l=120
X10 u2/VDD u2/A1 u2/ZN u2/VNW pfet_05v0 ad=0 pd=0 as=0 ps=0 w=226 l=100
X11 u2/a_245_68# u2/A2 u2/VSS VSUBS nfet_05v0 ad=0 pd=0 as=0 ps=0 w=164 l=120
C0 u2/VNW u2/ZN 0.04134f
C1 u2/VDD u0/A2 0.04881f
C2 u2/VNW u1/A1 0.12122f
C3 u2/VNW u2/VDD 0.31412f
C4 u2/VDD u0/a_245_68# 0
C5 u1/ZN u2/A2 0.07165f
C6 u1/ZN u1/a_245_68# 0
C7 u1/ZN u0/A1 0
C8 u2/VNW u1/A2 0.1256f
C9 u1/ZN u2/VSS 0.13796f
C10 u1/ZN u0/ZN 0.00724f
C11 u1/ZN u2/A1 0.00789f
C12 u2/VNW u0/A2 0.1254f
C13 u2/VSS u2/A2 0.05527f
C14 u2/VSS u1/a_245_68# 0.00317f
C15 u2/VSS u0/A1 0.13456f
C16 u1/ZN u2/ZN 0.00724f
C17 u0/ZN u1/a_245_68# 0
C18 u0/ZN u0/A1 0.36366f
C19 u2/VSS u0/ZN 0.13796f
C20 u2/A1 u2/A2 0.2264f
C21 u2/VSS u2/A1 0.13214f
C22 u0/a_245_68# u0/A2 0
C23 u2/a_245_68# u1/ZN 0
C24 u2/ZN u2/A2 0.04777f
C25 u1/ZN u1/A1 0.36366f
C26 u2/VSS u2/ZN 0.09851f
C27 u2/A1 u2/ZN 0.36366f
C28 u2/a_245_68# u2/A2 0
C29 u2/a_245_68# u2/VSS 0.00268f
C30 u1/A1 u2/A2 0.0148f
C31 u1/A1 u1/a_245_68# 0.00883f
C32 u2/VSS u1/A1 0.13456f
C33 u2/VDD u1/ZN 0.24816f
C34 u1/A1 u0/ZN 0.00789f
C35 u2/a_245_68# u2/A1 0.00883f
C36 u2/a_245_68# u2/ZN 0
C37 u2/VDD u2/A2 0.04933f
C38 u2/VDD u1/a_245_68# 0
C39 u2/VDD u0/A1 0.0371f
C40 u2/ZN u1/A1 0
C41 u2/VDD u2/VSS 0.05312f
C42 u2/VDD u0/ZN 0.24758f
C43 u2/VDD u2/A1 0.03659f
C44 u1/ZN u1/A2 0.04777f
C45 u2/VDD u2/ZN 0.24758f
C46 u1/A2 u1/a_245_68# 0
C47 u1/A2 u0/A1 0.0148f
C48 u2/VSS u1/A2 0.056f
C49 u2/a_245_68# u2/VDD 0
C50 u1/A2 u0/ZN 0.07165f
C51 u2/VDD u1/A1 0.0371f
C52 u0/A2 u0/A1 0.2264f
C53 u2/VSS u0/A2 0.05529f
C54 u0/ZN u0/A2 0.04777f
C55 u2/VNW u1/ZN 0.04264f
C56 u1/A2 u1/A1 0.2264f
C57 u2/VNW u2/A2 0.1256f
C58 u2/VNW u0/A1 0.12122f
C59 u2/VNW u2/VSS 0.01852f
C60 u2/VNW u0/ZN 0.04307f
C61 u2/VDD u1/A2 0.04933f
C62 u2/VNW u2/A1 0.11976f
C63 u0/a_245_68# u0/A1 0.00883f
C64 u2/VSS u0/a_245_68# 0.00317f
C65 u0/ZN u0/a_245_68# 0
C66 u2/ZN VSUBS 0.08833f
C67 u2/A1 VSUBS 0.17937f
C68 u2/A2 VSUBS 0.20324f
C69 u2/VSS VSUBS 0.57112f
C70 u1/ZN VSUBS 0.08833f
C71 u2/VDD VSUBS 0.43336f
C72 u1/A1 VSUBS 0.17937f
C73 u1/A2 VSUBS 0.20324f
C74 u2/VNW VSUBS 2.87801f
C75 u0/ZN VSUBS 0.08833f
C76 u0/A1 VSUBS 0.17937f
C77 u0/A2 VSUBS 0.20324f
